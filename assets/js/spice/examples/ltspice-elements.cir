* Viewer grammar coverage: all documented LTspice 24+ element prefixes
.title LTspice element families
V1 in 0 PULSE(0 1 0 1n 1n 1u 2u 4) Rser=0
VSENSE sense 0 0
I1 in 0 PWL(0 0 1u 1m) load
R1 in mid 1k tc=.001
C1 mid 0 Q=100p*x ic=0
LA mid tank Flux=1m*tanh(x)
LB tank 0 2m Rser=0
K1 LA LB .8
D1 mid 0 DD m=2
Q1 in mid 0 QN off
M1 in mid 0 0 MN L=1u W=10u
MPOWER in mid 0 MPWR
J1 in mid 0 JN
Z1 in mid 0 ZN
ZIGBT in mid 0 ZI
E1 ev 0 in mid 2
G1 gi 0 in mid table=(0,0,1,1m)
F1 fi 0 VSENSE 2
H1 hv 0 VSENSE 1k
S1 in sw mid 0 SWMOD off
W1 sw 0 VSENSE CSMOD off
T1 in 0 t 0 ZO=50 TD=1n
O1 t 0 o 0 LTMOD
U1 o u 0 RCMOD L=1
B1 bv 0 V=if(V(mid)>0,tanh(V(mid)),0) tripdv=1m
BR1 mid 0 R=1k+time
BP1 mid 0 P=1m
A1 in mid 0 0 0 inverted logic 0 AND Vhigh=1.8 Td=1n
X1 in x 0 DIVIDER top=1k bot=2k
@1 in mid fstart=10 fend=1Meg refnode=0 intnode=mid
&1 mid 0 in 0
Ö1 ota in 0 mid in Gm1=1m Gm2=0 Ibias=1u
.model DD D(Is=1n)
.model QN NPN(Bf=100)
.model MN NMOS(Vto=1 Kp=1m)
.model MPWR VDMOS(Vto=2 Kp=1)
.model JN NJF(Vto=-2 Beta=1m)
.model ZN NMF(Vto=-1 Beta=1m)
.model ZI NIGBT(Vt=4)
.model SWMOD SW(Ron=1 Roff=1Meg Vt=.5)
.model CSMOD CSW(Ron=1 Roff=1Meg It=1m)
.model LTMOD LTRA(R=1 L=1u G=0 C=10p Len=1)
.model RCMOD URC(Rperl=1k Cperl=1n)
.subckt DIVIDER a b c
Rtop a b {top}
Rbot b c {bot}
.ends DIVIDER
.tran 0 10u
.end
